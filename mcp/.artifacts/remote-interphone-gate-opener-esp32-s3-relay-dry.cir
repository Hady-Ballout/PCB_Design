* Remote interphone gate opener — ESP32-S3 + relay dry contact, USB-C 5V
* Generated by Prompt-to-PCB Generator
* J1 usb_c (wiring-only, not simulated)
R1 CC1 0 5.1k
R2 CC2 0 5.1k
V1 VBUS 0 DC 5
D1 0 VBUS DTVS_6R8
V2 3V3 0 DC 3.3
C1 VBUS 0 10u
C2 VBUS 0 100n
C3 3V3 0 10u
C4 3V3 0 100n
C5 EN 0 1u
R3 EN 3V3 10k
R4 BOOT 3V3 10k
R5 LED_STAT LED_A 330
D2 LED_A 0 DRED
R6 BOOT 0 10Meg
R7 EN 0 10Meg
* U2 relay_module (wiring-only, not simulated)
* J2 terminal_block (wiring-only, not simulated)
* U1 esp32_s3_wroom (microcontroller board, not simulated)
.model DGEN D(IS=1e-14 RS=1 N=1)
.model DRED D(IS=1e-20 N=2 RS=10 CJO=2p BV=5 IBV=10u)
.model Q2N2222 NPN(IS=1e-14 BF=200 VAF=100)
.model DTVS_6R8 D(IS=1e-14 RS=0.5 N=1 BV=6.8 IBV=1m)
.tran 0.1ms 20ms
.op
.end
